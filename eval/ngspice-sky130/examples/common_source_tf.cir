* Sky130 common-source small-signal transfer
.include "../models/sky130.lib.spice"

Vdd vdd 0 1.8
Vin in 0 0.9 AC 1
Rd vdd out 20k

Xn out in 0 0 sky130_fd_pr__nfet_01v8 w=1.26 l=0.15

.op
.tf v(out) Vin

.end
