* Sky130 source follower small-signal transfer
.include "../models/sky130.lib.spice"

Vdd vdd 0 1.8
Vin in 0 0.9 AC 1

Xn vdd in out 0 sky130_fd_pr__nfet_01v8 w=4.2 l=0.15
Rs out 0 10k

.op
.tf v(out) Vin

.end
