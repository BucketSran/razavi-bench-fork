* gm and intrinsic gain trend, sky130A tt
.lib sources/sky130/volare/volare/sky130/versions/c6d73a35f524070e85faff4a6a9eef49553ebc2b/sky130A/libs.tech/ngspice/sky130.lib.spice tt
Vd1 d1 0 1.8
Vd2 d2 0 1.8
Vg g 0 0.9
Vs s 0 0
Xshort d1 g s 0 sky130_fd_pr__nfet_01v8 w=1.26 l=0.15
Xlong  d2 g s 0 sky130_fd_pr__nfet_01v8 w=2.52 l=0.30
.op
.control
run
let gm_short=@m.xshort.msky130_fd_pr__nfet_01v8[gm]
let gds_short=@m.xshort.msky130_fd_pr__nfet_01v8[gds]
let gain_short=gm_short/gds_short
let gm_long=@m.xlong.msky130_fd_pr__nfet_01v8[gm]
let gds_long=@m.xlong.msky130_fd_pr__nfet_01v8[gds]
let gain_long=gm_long/gds_long
print gm_short gds_short gain_short gm_long gds_long gain_long
.endc
.end
