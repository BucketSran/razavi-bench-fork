* common source tf
.lib sources/sky130/volare/volare/sky130/versions/c6d73a35f524070e85faff4a6a9eef49553ebc2b/sky130A/libs.tech/ngspice/sky130.lib.spice tt
Vdd vdd 0 1.8
Vin in 0 0.9 AC 1
Rd vdd out 20k
Xn out in 0 0 sky130_fd_pr__nfet_01v8 w=1.26 l=0.15
.op
.tf v(out) Vin
.end
