* output resistance comparison
.lib sources/sky130/volare/volare/sky130/versions/c6d73a35f524070e85faff4a6a9eef49553ebc2b/sky130A/libs.tech/ngspice/sky130.lib.spice tt
Vdd vdd 0 1.8
Vb1 b1 0 0.75
Vb2 b2 0 1.25
Iref vdd out1 20u
Xsingle out1 b1 0 0 sky130_fd_pr__nfet_01v8 w=1.26 l=0.5
Iref2 vdd out2 20u
Xlow x b1 0 0 sky130_fd_pr__nfet_01v8 w=1.26 l=0.5
Xcas out2 b2 x 0 sky130_fd_pr__nfet_01v8 w=1.26 l=0.5
Vtest1 out1 0 0.9
Vtest2 out2 0 0.9
.op
.control
run
let ro_single=1/@m.xsingle.msky130_fd_pr__nfet_01v8[gds]
let ro_cas_est=1/@m.xcas.msky130_fd_pr__nfet_01v8[gds]
print ro_single ro_cas_est
.endc
.end
