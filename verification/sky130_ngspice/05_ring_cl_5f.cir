* three-stage sky130 ring oscillator, CL=5f
.lib sources/sky130/volare/volare/sky130/versions/c6d73a35f524070e85faff4a6a9eef49553ebc2b/sky130A/libs.tech/ngspice/sky130.lib.spice tt
Vdd vdd 0 1.8
.subckt inv in out vdd vss
Xn out in vss vss sky130_fd_pr__nfet_01v8 w=1.26 l=0.15
Xp out in vdd vdd sky130_fd_pr__pfet_01v8 w=2.52 l=0.15
.ends
X1 n3 n1 vdd 0 inv
X2 n1 n2 vdd 0 inv
X3 n2 n3 vdd 0 inv
C1 n1 0 5f
C2 n2 0 5f
C3 n3 0 5f
.ic v(n1)=1.8 v(n2)=0 v(n3)=0
.tran 1p 20n uic
.control
run
meas tran t1 when v(n1)=0.9 rise=5
meas tran t2 when v(n1)=0.9 rise=6
let freq=1/(t2-t1)
print freq
.endc
.end
