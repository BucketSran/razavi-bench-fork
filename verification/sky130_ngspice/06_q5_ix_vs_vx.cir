* Part 1 Q5: sweep gate voltage VX with drain fixed at 1 V.
.lib sources/sky130/volare/volare/sky130/versions/c6d73a35f524070e85faff4a6a9eef49553ebc2b/sky130A/libs.tech/ngspice/sky130.lib.spice tt

Vd d 0 1.0
Vx g 0 0
Xn d g 0 0 sky130_fd_pr__nfet_01v8 w=1.26 l=0.15

.control
dc Vx 0 1.8 0.1
let ix = -i(Vd)
print v(g) ix
.endc
.end
