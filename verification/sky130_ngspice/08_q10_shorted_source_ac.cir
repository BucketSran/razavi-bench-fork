* Part 1 Q10: input capacitor drives a node that is shorted to ground.
.lib sources/sky130/volare/volare/sky130/versions/c6d73a35f524070e85faff4a6a9eef49553ebc2b/sky130A/libs.tech/ngspice/sky130.lib.spice tt

Vdd vdd 0 1.8
Vin in 0 0 AC 1
Vb g 0 0.9
Rd vdd out 20k
C1 in 0 1p
Xn out g 0 0 sky130_fd_pr__nfet_01v8 w=1.26 l=0.15

.control
op
ac dec 1 1k 1Meg
print vm(out)
.endc
.end
